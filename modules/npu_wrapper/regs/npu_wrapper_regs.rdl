addrmap npu_wrapper_regs {
    name = "NPU Control and Status Registers";
    
    reg {
        name = "DMA Source Address";
        field { hw=r; sw=rw; } value[32];
    } REG_RDMA_ADDR @0x0;

    reg {
        name = "DMA Transfer Length";
        field { hw=r; sw=rw; } value[20];
    } REG_RDMA_LEN @0x4;

    reg {
        name = "DMA Control";
        field { 
            hw=r; sw=w; 
            singlepulse; // Automatically makes it a 1-cycle self-clearing pulse
	    reset = 1'b0;
        } valid[1];
    } REG_RDMA_CTRL @0x8;
};

// peakrdl regblock npu_wrapper_regs.rdl --cpuif axi4-lite -o ./peakrdl/
// peakrdl html npu_wrapper_regs.rdl -o ./docs/register_map/
